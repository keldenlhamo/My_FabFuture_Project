*Test for resistor block

* Input source- sinusoidal sin (Voffset Vamp Freq TD Theta Phase)
Vin in 0 sin(0 1 1 0 0 0)

* Resistor under test(1k ohm)
R1 in out 1k

*Load resistor to ground ( forms voltage divider)
Rload out 0 1k

* Simulation: transient analysis, 0 to 5 sec, 0.01s step
.tran 0.01 5

* Control block for ngspice
.control
set wr_singlescale
set wr_vecnames
Resistor.osdi
run
wrdata resistor_output.txt V(in) V(out)
.endc

.end
